* =============================================================================
* TATTO PROJECT -- ULTIMATE HOSTILE STRESS-TEST ORACLE (PHASE 7.3)
* File: simulations/spice/stress_testbench.cir
* Mission: Closed-Loop Line Disturbance Stress Rejection Validation
* Stimuli: Dynamic Sine, Triangular, High-Slew Sawtooth, and Noise Surges
* Standard: Berkeley SPICE3f5 / NGSPICE / CTAN CircuiTikZ 1:1 Fidelity
* Target Output: 12.0 V Regulated DC under Hostile Stress and 1.20 A Load
* =============================================================================

* -----------------------------------------------------------------------------
* 1. TESTBENCH PARAMETRIC DECLARATIONS
* -----------------------------------------------------------------------------
.param k_T          = 0.15
.param L_pri_val    = 10.0
.param L_sec_val    = {L_pri_val * (k_T * k_T)}
.param K_trans_val  = 0.9995
.param R_sec_w_val  = 0.05

.param C_filt_val   = 4700u
.param R_bleed_val  = 1.0k
.param R_bias_val   = 1.5k
.param I_tail_val   = 2.0m
.param R_E_val      = 100.0
.param R_C_val      = 2.2k
.param C_c_val      = 100p
.param R_sc_val     = 0.33
.param C_out_val    = 100u

.param R1_val       = 4.47k
.param R2_val       = 3.3k
.param R_load_val   = 10.0

* =============================================================================
* STAGE 1: HOSTILE AC POWER SOURCE & CONVERSION
* =============================================================================
* Hostile Arbitrary Multi-Phase Disturbance Waveform
V_AC    N_PRI_1 N_PRI_2 PWL(
+ 0.000m 0.00 0.100m 5.71 0.200m 11.53 0.300m 17.44 0.400m 23.44 0.500m 29.52 0.600m 35.66 0.700m 41.85 0.800m 48.09 0.900m 54.34 1.000m 60.61 1.100m 66.87 1.200m 73.10 1.300m 79.29 1.400m 85.42 1.500m 91.46 1.600m 97.41 1.700m 103.22 1.800m 108.90 1.900m 114.40 2.000m 119.71 2.100m 124.81 2.200m 129.66 2.300m 134.26 2.400m 138.57 2.500m 142.56 2.600m 146.23 2.700m 149.53 2.800m 152.46 2.900m 154.99 3.000m 157.09 3.100m 158.76 3.200m 159.96 3.300m 160.68 3.400m 160.91 3.500m 160.63 3.600m 159.83 3.700m 158.50 3.800m 156.63 3.900m 154.21 4.000m 151.24 4.100m 147.72 4.200m 143.65 4.300m 139.04 4.400m 133.88 4.500m 128.19 4.600m 121.99 4.700m 115.28 4.800m 108.08 4.900m 100.42 5.000m 92.32 5.100m 83.81 5.200m 74.91 5.300m 65.65 5.400m 56.08 5.500m 46.21 5.600m 36.11 5.700m 25.79 5.800m 15.32 5.900m 4.72 6.000m -5.96 6.100m -16.67 6.200m -27.36 6.300m -38.00 6.400m -48.53 6.500m -58.90 6.600m -69.07 6.700m -79.00 6.800m -88.64 6.900m -97.94 7.000m -106.87 7.100m -115.39 7.200m -123.45 7.300m -131.03 7.400m -138.09 7.500m -144.59 7.600m -150.52 7.700m -155.84 7.800m -160.55 7.900m -164.61 8.000m -168.01 8.100m -170.75 8.200m -172.81 8.300m -174.19 8.400m -174.89 8.500m -174.92 8.600m -174.27 8.700m -172.96 8.800m -171.00 8.900m -168.41 9.000m -165.20 9.100m -161.39 9.200m -157.01 9.300m -152.08 9.400m -146.64 9.500m -140.70 9.600m -134.31 9.700m -127.49 9.800m -120.28 9.900m -112.71 10.000m -104.81 10.100m -96.63 10.200m -88.20 10.300m -79.55 10.400m -70.72 10.500m -61.75 10.600m -52.66 10.700m -43.51 10.800m -34.30 10.900m -25.09 11.000m -15.90 11.100m -6.75 11.200m 2.32 11.300m 11.29 11.400m 20.13 11.500m 28.83 11.600m 37.35 11.700m 45.69 11.800m 53.82 11.900m 61.72 12.000m 69.40 12.100m 76.82 12.200m 83.99 12.300m 90.89 12.400m 97.51 12.500m 103.86 12.600m 109.93 12.700m 115.71 12.800m 121.21 12.900m 126.43 13.000m 131.36 13.100m 136.02 13.200m 140.39 13.300m 144.50 13.400m 148.35 13.500m 151.94 13.600m 155.27 13.700m 158.37 13.800m 161.23 13.900m 163.87 14.000m 166.29 14.100m 168.51 14.200m 170.53 14.300m 172.37 14.400m 174.03 14.500m 175.53 14.600m 176.87 14.700m 178.07 14.800m 179.13 14.900m 180.07 15.000m 180.90 15.100m 181.61 15.200m 182.24 15.300m 182.77 15.400m 183.22 15.500m 183.61 15.600m 183.93 15.700m 184.19 15.800m 184.40 15.900m 184.57 16.000m 184.71 16.100m 184.81 16.200m 184.88 16.300m 184.93 16.400m 184.97 16.500m 184.99 16.600m 185.00 16.700m 185.00 16.800m 184.99 16.900m 184.99 17.000m 184.97 17.100m 184.96 17.200m 184.95 17.300m 184.93 17.400m 184.91 17.500m 184.89 17.600m 184.86 17.700m 184.83 17.800m 184.80 17.900m 184.75 18.000m 184.69 18.100m 184.61 18.200m 184.52 18.300m 184.40 18.400m 184.26 18.500m 184.08 18.600m 183.87 18.700m 183.62 18.800m 183.33 18.900m 182.98 19.000m 182.58 19.100m 182.12 19.200m 181.59 19.300m 180.99 19.400m 180.32 19.500m 179.56 19.600m 178.71 19.700m 177.77 19.800m 176.72 19.900m 175.57 20.000m 174.32 20.100m 172.94 20.200m 171.45 20.300m 169.83 20.400m 168.08 20.500m 166.19 20.600m 164.17 20.700m 162.01 20.800m 159.70 20.900m 157.25 21.000m 154.65 21.100m 151.90 21.200m 149.00 21.300m 145.94 21.400m 142.74 21.500m 139.38 21.600m 135.87 21.700m 132.21 21.800m 128.41 21.900m 124.46 22.000m 120.37 22.100m 116.14 22.200m 111.79 22.300m 107.30 22.400m 102.69 22.500m 97.97 22.600m 93.14 22.700m 88.20 22.800m 83.18 22.900m 78.06 23.000m 72.87 23.100m 67.60 23.200m 62.28 23.300m 56.90 23.400m 51.49 23.500m 46.04 23.600m 40.56 23.700m 35.08 23.800m 29.59 23.900m 24.11 24.000m 18.64 24.100m 13.20 24.200m 7.79 24.300m 2.44 24.400m -2.87 24.500m -8.11 24.600m -13.29 24.700m -18.38 24.800m -23.38 24.900m -28.29 25.000m -33.10 25.100m -159.72 25.200m -154.44 25.300m -149.16 25.400m -143.88 25.500m -138.60 25.600m -133.32 25.700m -128.04 25.800m -122.76 25.900m -117.48 26.000m -112.20 26.100m -106.92 26.200m -101.64 26.300m -96.36 26.400m -91.08 26.500m -85.80 26.600m -80.52 26.700m -75.24 26.800m -69.96 26.900m -64.68 27.000m -59.40 27.100m -54.12 27.200m -48.84 27.300m -43.56 27.400m -38.28 27.500m -33.00 27.600m -27.72 27.700m -22.44 27.800m -17.16 27.900m -11.88 28.000m -6.60 28.100m -1.32 28.200m 3.96 28.300m 9.24 28.400m 14.52 28.500m 19.80 28.600m 25.08 28.700m 30.36 28.800m 35.64 28.900m 40.92 29.000m 46.20 29.100m 51.48 29.200m 56.76 29.300m 62.04 29.400m 67.32 29.500m 72.60 29.600m 77.88 29.700m 83.16 29.800m 88.44 29.900m 93.72 30.000m 99.00 30.100m 104.28 30.200m 109.56 30.300m 114.84 30.400m 120.12 30.500m 125.40 30.600m 130.68 30.700m 135.96 30.800m 141.24 30.900m 146.52 31.000m 151.80 31.100m 157.08 31.200m 162.36 31.300m 162.36 31.400m 157.08 31.500m 151.80 31.600m 146.52 31.700m 141.24 31.800m 135.96 31.900m 130.68 32.000m 125.40 32.100m 120.12 32.200m 114.84 32.300m 109.56 32.400m 104.28 32.500m 99.00 32.600m 93.72 32.700m 88.44 32.800m 83.16 32.900m 77.88 33.000m 72.60 33.100m 67.32 33.200m 62.04 33.300m 56.76 33.400m 51.48 33.500m 46.20 33.600m 40.92 33.700m 35.64 33.800m 30.36 33.900m 25.08 34.000m 19.80 34.100m 14.52 34.200m 9.24 34.300m 3.96 34.400m -1.32 34.500m -6.60 34.600m -11.88 34.700m -17.16 34.800m -22.44 34.900m -27.72 35.000m -33.00 35.100m -38.28 35.200m -43.56 35.300m -48.84 35.400m -54.12 35.500m -59.40 35.600m -64.68 35.700m -69.96 35.800m -75.24 35.900m -80.52 36.000m -85.80 36.100m -91.08 36.200m -96.36 36.300m -101.64 36.400m -106.92 36.500m -112.20 36.600m -117.48 36.700m -122.76 36.800m -128.04 36.900m -133.32 37.000m -138.60 37.100m -143.88 37.200m -149.16 37.300m -154.44 37.400m -159.72 37.500m -165.00 37.600m -159.72 37.700m -154.44 37.800m -149.16 37.900m -143.88 38.000m -138.60 38.100m -133.32 38.200m -128.04 38.300m -122.76 38.400m -117.48 38.500m -112.20 38.600m -106.92 38.700m -101.64 38.800m -96.36 38.900m -91.08 39.000m -85.80 39.100m -80.52 39.200m -75.24 39.300m -69.96 39.400m -64.68 39.500m -59.40 39.600m -54.12 39.700m -48.84 39.800m -43.56 39.900m -38.28 40.000m -33.00 40.100m -27.72 40.200m -22.44 40.300m -17.16 40.400m -11.88 40.500m -6.60 40.600m -1.32 40.700m 3.96 40.800m 9.24 40.900m 14.52 41.000m 19.80 41.100m 25.08 41.200m 30.36 41.300m 35.64 41.400m 40.92 41.500m 46.20 41.600m 51.48 41.700m 56.76 41.800m 62.04 41.900m 67.32 42.000m 72.60 42.100m 77.88 42.200m 83.16 42.300m 88.44 42.400m 93.72 42.500m 99.00 42.600m 104.28 42.700m 109.56 42.800m 114.84 42.900m 120.12 43.000m 125.40 43.100m 130.68 43.200m 135.96 43.300m 141.24 43.400m 146.52 43.500m 151.80 43.600m 157.08 43.700m 162.36 43.800m 162.36 43.900m 157.08 44.000m 151.80 44.100m 146.52 44.200m 141.24 44.300m 135.96 44.400m 130.68 44.500m 125.40 44.600m 120.12 44.700m 114.84 44.800m 109.56 44.900m 104.28 45.000m 99.00 45.100m 93.72 45.200m 88.44 45.300m 83.16 45.400m 77.88 45.500m 72.60 45.600m 67.32 45.700m 62.04 45.800m 56.76 45.900m 51.48 46.000m 46.20 46.100m 40.92 46.200m 35.64 46.300m 30.36 46.400m 25.08 46.500m 19.80 46.600m 14.52 46.700m 9.24 46.800m 3.96 46.900m -1.32 47.000m -6.60 47.100m -11.88 47.200m -17.16 47.300m -22.44 47.400m -27.72 47.500m -33.00 47.600m -38.28 47.700m -43.56 47.800m -48.84 47.900m -54.12 48.000m -59.40 48.100m -64.68 48.200m -69.96 48.300m -75.24 48.400m -80.52 48.500m -85.80 48.600m -91.08 48.700m -96.36 48.800m -101.64 48.900m -106.92 49.000m -112.20 49.100m -117.48 49.200m -122.76 49.300m -128.04 49.400m -133.32 49.500m -138.60 49.600m -143.88 49.700m -149.16 49.800m -154.44 49.900m -159.72 50.000m -175.00 50.100m -164.27 50.200m -155.34 50.300m -149.53 50.400m -147.43 50.500m -148.68 50.600m -152.12 50.700m -156.02 50.800m -158.56 50.900m -158.23 51.000m -154.27 51.100m -146.77 51.200m -136.73 51.300m -125.77 51.400m -115.73 51.500m -108.23 51.600m -104.27 51.700m -103.94 51.800m -106.48 51.900m -110.38 52.000m -113.82 52.100m -115.07 52.200m -112.97 52.300m -107.16 52.400m -98.23 52.500m -87.50 52.600m -76.77 52.700m -67.84 52.800m -62.03 52.900m -59.93 53.000m -61.18 53.100m -64.62 53.200m -68.52 53.300m -71.06 53.400m -70.73 53.500m -66.77 53.600m -59.27 53.700m -49.23 53.800m -38.27 53.900m -28.23 54.000m -20.73 54.100m -16.77 54.200m -16.44 54.300m -18.98 54.400m -22.88 54.500m -26.32 54.600m -27.57 54.700m -25.47 54.800m -19.66 54.900m -10.73 55.000m 0.00 55.100m 10.73 55.200m 19.66 55.300m 25.47 55.400m 27.57 55.500m 26.32 55.600m 22.88 55.700m 18.98 55.800m 16.44 55.900m 16.77 56.000m 20.73 56.100m 28.23 56.200m 38.27 56.300m 49.23 56.400m 59.27 56.500m 66.77 56.600m 70.73 56.700m 71.06 56.800m 68.52 56.900m 64.62 57.000m 61.18 57.100m 59.93 57.200m 62.03 57.300m 67.84 57.400m 76.77 57.500m 87.50 57.600m 98.23 57.700m 107.16 57.800m 112.97 57.900m 115.07 58.000m 113.82 58.100m 110.38 58.200m 106.48 58.300m 103.94 58.400m 104.27 58.500m 108.23 58.600m 115.73 58.700m 125.77 58.800m 136.73 58.900m 146.77 59.000m 154.27 59.100m 158.23 59.200m 158.56 59.300m 156.02 59.400m 152.12 59.500m 148.68 59.600m 147.43 59.700m 149.53 59.800m 155.34 59.900m 164.27 60.000m -175.00 60.100m -164.27 60.200m -155.34 60.300m -149.53 60.400m -147.43 60.500m -148.68 60.600m -152.12 60.700m -156.02 60.800m -158.56 60.900m -158.23 61.000m -154.27 61.100m -146.77 61.200m -136.73 61.300m -125.77 61.400m -115.73 61.500m -108.23 61.600m -104.27 61.700m -103.94 61.800m -106.48 61.900m -110.38 62.000m -113.82 62.100m -115.07 62.200m -112.97 62.300m -107.16 62.400m -98.23 62.500m -87.50 62.600m -76.77 62.700m -67.84 62.800m -62.03 62.900m -59.93 63.000m -61.18 63.100m -64.62 63.200m -68.52 63.300m -71.06 63.400m -70.73 63.500m -66.77 63.600m -59.27 63.700m -49.23 63.800m -38.27 63.900m -28.23 64.000m -20.73 64.100m -16.77 64.200m -16.44 64.300m -18.98 64.400m -22.88 64.500m -26.32 64.600m -27.57 64.700m -25.47 64.800m -19.66 64.900m -10.73 65.000m 0.00 65.100m 10.73 65.200m 19.66 65.300m 25.47 65.400m 27.57 65.500m 26.32 65.600m 22.88 65.700m 18.98 65.800m 16.44 65.900m 16.77 66.000m 20.73 66.100m 28.23 66.200m 38.27 66.300m 49.23 66.400m 59.27 66.500m 66.77 66.600m 70.73 66.700m 71.06 66.800m 68.52 66.900m 64.62 67.000m 61.18 67.100m 59.93 67.200m 62.03 67.300m 67.84 67.400m 76.77 67.500m 87.50 67.600m 98.23 67.700m 107.16 67.800m 112.97 67.900m 115.07 68.000m 113.82 68.100m 110.38 68.200m 106.48 68.300m 103.94 68.400m 104.27 68.500m 108.23 68.600m 115.73 68.700m 125.77 68.800m 136.73 68.900m 146.77 69.000m 154.27 69.100m 158.23 69.200m 158.56 69.300m 156.02 69.400m 152.12 69.500m 148.68 69.600m 147.43 69.700m 149.53 69.800m 155.34 69.900m 164.27 70.000m -175.00 70.100m -164.27 70.200m -155.34 70.300m -149.53 70.400m -147.43 70.500m -148.68 70.600m -152.12 70.700m -156.02 70.800m -158.56 70.900m -158.23 71.000m -154.27 71.100m -146.77 71.200m -136.73 71.300m -125.77 71.400m -115.73 71.500m -108.23 71.600m -104.27 71.700m -103.94 71.800m -106.48 71.900m -110.38 72.000m -113.82 72.100m -115.07 72.200m -112.97 72.300m -107.16 72.400m -98.23 72.500m -87.50 72.600m -76.77 72.700m -67.84 72.800m -62.03 72.900m -59.93 73.000m -61.18 73.100m -64.62 73.200m -68.52 73.300m -71.06 73.400m -70.73 73.500m -66.77 73.600m -59.27 73.700m -49.23 73.800m -38.27 73.900m -28.23 74.000m -20.73 74.100m -16.77 74.200m -16.44 74.300m -18.98 74.400m -22.88 74.500m -26.32 74.600m -27.57 74.700m -25.47 74.800m -19.66 74.900m -10.73 75.000m 50.00 75.100m 34.63 75.200m 19.51 75.300m 4.82 75.400m -9.27 75.500m -22.59 75.600m -35.01 75.700m -46.42 75.800m -56.71 75.900m -65.84 76.000m -73.76 76.100m -80.49 76.200m -86.04 76.300m -90.47 76.400m -93.86 76.500m -96.31 76.600m -97.94 76.700m -98.89 76.800m -99.30 76.900m -99.31 77.000m -99.07 77.100m -98.71 77.200m -98.38 77.300m -98.17 77.400m -98.20 77.500m -98.53 77.600m -99.22 77.700m -100.31 77.800m -101.80 77.900m -103.68 78.000m -105.92 78.100m -108.46 78.200m -111.23 78.300m -114.15 78.400m -117.13 78.500m -120.07 78.600m -122.88 78.700m -125.48 78.800m -127.76 78.900m -129.67 79.000m -131.15 79.100m -132.14 79.200m -132.64 79.300m -132.64 79.400m -132.15 79.500m -131.22 79.600m -129.89 79.700m -128.23 79.800m -126.33 79.900m -124.27 80.000m -122.15 80.100m -120.07 80.200m -118.12 80.300m -116.38 80.400m -114.93 80.500m -113.84 80.600m -113.13 80.700m -112.85 80.800m -112.97 80.900m -113.49 81.000m -114.36 81.100m -115.49 81.200m -116.82 81.300m -118.22 81.400m -119.58 81.500m -120.75 81.600m -121.60 81.700m -121.98 81.800m -121.75 81.900m -120.77 82.000m -118.92 82.100m -116.09 82.200m -112.20 82.300m -107.18 82.400m -101.00 82.500m -93.65 82.600m -85.16 82.700m -75.58 82.800m -64.98 82.900m -53.48 83.000m -41.22 83.100m -28.34 83.200m -15.02 83.300m -1.44 83.400m 12.20 83.500m 25.73 83.600m 38.93 83.700m 51.65 83.800m 63.70 83.900m 74.95 84.000m 85.26 84.100m 94.54 84.200m 102.71 84.300m 109.73 84.400m 115.60 84.500m 120.31 84.600m 123.93 84.700m 126.51 84.800m 128.16 84.900m 128.99 85.000m 129.12 85.100m 128.69 85.200m 127.85 85.300m 126.74 85.400m 125.50 85.500m 124.27 85.600m 123.17 85.700m 122.29 85.800m 121.72 85.900m 121.52 86.000m 121.74 86.100m 122.38 86.200m 123.44 86.300m 124.89 86.400m 126.69 86.500m 128.76 86.600m 131.04 86.700m 133.42 86.800m 135.82 86.900m 138.14 87.000m 140.29 87.100m 142.17 87.200m 143.72 87.300m 144.86 87.400m 145.56 87.500m 145.78 87.600m 145.51 87.700m 144.76 87.800m 143.56 87.900m 141.96 88.000m 140.03 88.100m 137.83 88.200m 135.46 88.300m 133.00 88.400m 130.56 88.500m 128.24 88.600m 126.11 88.700m 124.26 88.800m 122.75 88.900m 121.63 89.000m 120.93 89.100m 120.66 89.200m 120.79 89.300m 121.30 89.400m 122.12 89.500m 123.16 89.600m 124.33 89.700m 125.50 89.800m 126.54 89.900m 127.31 90.000m 177.33 90.100m 175.50 90.200m 173.03 90.300m 169.78 90.400m 165.65 90.500m 160.53 90.600m 154.35 90.700m 147.08 90.800m 138.68 90.900m 129.17 91.000m 118.60 91.100m 107.03 91.200m 94.56 91.300m 81.31 91.400m 67.44 91.500m 53.11 91.600m 38.50 91.700m 23.79 91.800m 9.17 91.900m -5.16 92.000m -19.02 92.100m -32.25 92.200m -44.68 92.300m -56.19 92.400m -66.66 92.500m -76.03 92.600m -84.23 92.700m -91.24 92.800m -97.07 92.900m -101.76 93.000m -105.37 93.100m -107.99 93.200m -109.72 93.300m -110.69 93.400m -111.04 93.500m -110.91 93.600m -110.44 93.700m -109.78 93.800m -109.06 93.900m -108.41 94.000m -107.94 94.100m -107.74 94.200m -107.88 94.300m -108.40 94.400m -109.33 94.500m -110.67 94.600m -112.41 94.700m -114.49 94.800m -116.86 94.900m -119.44 95.000m -122.15 95.100m -124.90 95.200m -127.59 95.300m -130.12 95.400m -132.42 95.500m -134.38 95.600m -135.96 95.700m -137.09 95.800m -137.74 95.900m -137.90 96.000m -137.56 96.100m -136.75 96.200m -135.52 96.300m -133.92 96.400m -132.02 96.500m -129.91 96.600m -127.68 96.700m -125.43 96.800m -123.25 96.900m -121.23 97.000m -119.46 97.100m -118.01 97.200m -116.93 97.300m -116.25 97.400m -116.00 97.500m -116.15 97.600m -116.69 97.700m -117.56 97.800m -118.68 97.900m -119.95 98.000m -121.27 98.100m -122.49 98.200m -123.49 98.300m -124.12 98.400m -124.24 98.500m -123.70 98.600m -122.37 98.700m -120.13 98.800m -116.89 98.900m -112.57 99.000m -107.10 99.100m -100.47 99.200m -92.68 99.300m -83.76 99.400m -73.77 99.500m -62.81 99.600m -50.99 99.700m -38.45 99.800m -25.36 99.900m -11.88
+ )

L1      N_PRI_1 N_PRI_2 {L_pri_val}
L2      SEC_A1  N_SEC_B {L_sec_val}
K12     L1      L2      {K_trans_val}
R_SEC   N_SEC_B SEC_A2  {R_sec_w_val}

* Full-Wave Diode Bridge (D1 - D4)
D1      SEC_A1  V_RAW   D1N4007
D2      SEC_A2  V_RAW   D1N4007
D3      0       SEC_A1  D1N4007
D4      0       SEC_A2  D1N4007

* Bulk Filter Capacitor C_filt & Bleeder Resistor R_bleed
C_FILT  V_RAW   0       {C_filt_val}
R_BLEED V_RAW   0       {R_bleed_val}

* =============================================================================
* STAGE 2: BIAS & REFERENCE (R_bias, Zener Diode D_Z, Reference Node V_ref)
* =============================================================================
R_BIAS  V_RAW   V_REF   {R_bias_val}
D_Z     0       V_REF   BZX84C5V1

* =============================================================================
* STAGE 3: ERROR AMPLIFIER (Discrete BJT Level: Diff Pair & Current Mirror)
* =============================================================================
Q1      N_C13   V_REF   N_TAIL  2N3904
Q2      N_C24   N_FB    N_TAIL  2N3904
I_TAIL  N_TAIL  0       {I_tail_val}
Q3      N_C13   N_C13   V_RAW   2N3906
Q4      N_C24   N_C13   V_RAW   2N3906

* =============================================================================
* STAGE 4: VOLTAGE AMPLIFIER STAGE (VAS: Q5, R_E, R_C, Miller C_c)
* =============================================================================
Q5      N_VAS_OUT N_C24 N_Q5_E  2N3904
R_E     N_Q5_E  0       {R_E_val}
R_C     V_RAW   N_VAS_OUT {R_C_val}
C_C     N_VAS_OUT N_C24 {C_c_val}

* =============================================================================
* STAGE 5: PASS ELEMENT, CURRENT LIMITING & CLOSED FEEDBACK LOOP
* =============================================================================
Q_DRV   V_RAW   N_VAS_OUT N_QPASS_B 2N3904
Q_PASS  V_RAW   N_QPASS_B N_SENSE TIP31C
R_SC    N_SENSE V_OUT   {R_sc_val}
Q_LIMIT N_VAS_OUT N_SENSE V_OUT 2N3904
C_OUT   V_OUT   0       {C_out_val}

R1      V_OUT   N_FB    {R1_val}
R2      N_FB    0       {R2_val}
R_LOAD  V_OUT   0       {R_load_val}

* =============================================================================
* DEVICE SEMICONDUCTOR MODELS (Physics-Based JEDEC Models)
* =============================================================================
.model D1N4007 D(Is=7.027n Rs=0.03415 N=1.802 Bv=1000 Ibv=0.05u Cjo=10p Vj=0.75)
.model BZX84C5V1 D(Is=1e-15 Bv=5.1 Ibv=5m Nbv=1.2 Rs=0.5)
.model 2N3904 NPN(Is=1e-14 Bf=200 Vaf=100 Cjc=4p Cje=8p Tf=0.3n)
.model 2N3906 PNP(Is=1e-14 Bf=180 Vaf=100 Cjc=4.5p Cje=10p Tf=0.35n)
.model TIP31C NPN(Is=1e-12 Bf=60 Vaf=100 Cjc=50p Cje=120p Tf=10n)

* =============================================================================
* SIMULATION DIRECTIVES & SOLVER CONTROL
* =============================================================================
.options method=gear reltol=1e-4 gmin=1e-12 abstol=1e-12
.tran 10u 100m uic

.control
  run
  meas tran Vac_max MAX v(N_PRI_1, N_PRI_2) from=20m to=100m
  meas tran Vac_min MIN v(N_PRI_1, N_PRI_2) from=20m to=100m
  meas tran Vraw_avg AVG v(V_RAW) from=20m to=100m
  meas tran Vraw_rip PP v(V_RAW) from=20m to=100m
  meas tran Vref_avg AVG v(V_REF) from=20m to=100m
  meas tran Vout_avg AVG v(V_OUT) from=20m to=100m
  meas tran Vout_rip PP v(V_OUT) from=20m to=100m
  meas tran Iout_avg AVG i(R_LOAD) from=20m to=100m
  print Vac_max Vac_min Vraw_avg Vraw_rip Vref_avg Vout_avg Vout_rip Iout_avg
.endc

.end
